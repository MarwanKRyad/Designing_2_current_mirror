ADE simulation setup
Run mode: Single Run, Sweeps and Corners
Tests:
  rev:why2:1: rev/why2/schematic, simulator spectre
Global variables:
  C = 1
  L = 50u
  M = 40
  Vout = 500m
