ADE simulation setup
Run mode: Single Run, Sweeps and Corners
Tests:
  rev:tak2.2:1: rev/tak2.2/schematic, simulator spectre
Global variables:
  l = 10u
  M = 4
  c = 5
  vout = 500m
